(setq lambda_variable (lambda () t))

(defun nonlocal () ())

(let ( ( local_lambda (lambda _ _) )
       )

  (defun local_fun (a) (list a))

  (defglobalfun global_fun (a b) (list a b))

  );closure
